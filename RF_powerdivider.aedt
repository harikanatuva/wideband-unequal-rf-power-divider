# Ansys Electronics Desktop project, version 2024.2
materials:
  vacuum: permittivity=1
  FR4_epoxy: permittivity=4.4 dielectric_loss_tangent=0.02
  PMLGroup1_Z_1: permittivity{anisotropic component1=1.1 component2=1.1 component3=0.45454545} permeability{anisotropic component1=1.1 component2=1.1 component3=0.45454545} dielectric_loss_tangent{anisotropic component1=1 component2=1 component3=-1} magnetic_loss_tangent{anisotropic component1=1 component2=1 component3=-1}
  PMLGroup1_XZ_1: permittivity{anisotropic component1=1 component2=0.01 component3=1} permeability{anisotropic component1=1 component2=0.01 component3=1} dielectric_loss_tangent{anisotropic component1=0 component2=242 component3=0} magnetic_loss_tangent{anisotropic component1=0 component2=242 component3=0}
  PMLGroup1_YZ_1: permittivity{anisotropic component1=0.01 component2=1 component3=1} permeability{anisotropic component1=0.01 component2=1 component3=1} dielectric_loss_tangent{anisotropic component1=242 component2=0 component3=0} magnetic_loss_tangent{anisotropic component1=242 component2=0 component3=0}
  PMLGroup1_XYZ_1: permittivity{anisotropic component1=1.1 component2=1.1 component3=1.1} permeability{anisotropic component1=1.1 component2=1.1 component3=1.1} dielectric_loss_tangent{anisotropic component1=1 component2=1 component3=1} magnetic_loss_tangent{anisotropic component1=1 component2=1 component3=1}
  PMLGroup2_Z_1: permittivity{anisotropic component1=1.1193654 component2=1.1193654 component3=0.44668168} permeability{anisotropic component1=1.1193654 component2=1.1193654 component3=0.44668168} dielectric_loss_tangent{anisotropic component1=1 component2=1 component3=-1} magnetic_loss_tangent{anisotropic component1=1 component2=1 component3=-1}
  PMLGroup2_XZ_1: permittivity{anisotropic component1=1 component2=0.01 component3=1} permeability{anisotropic component1=1 component2=0.01 component3=1} dielectric_loss_tangent{anisotropic component1=0 component2=250.59576 component3=0} magnetic_loss_tangent{anisotropic component1=0 component2=250.59576 component3=0}
  PMLGroup2_YZ_1: permittivity{anisotropic component1=0.01 component2=1 component3=1} permeability{anisotropic component1=0.01 component2=1 component3=1} dielectric_loss_tangent{anisotropic component1=250.59576 component2=0 component3=0} magnetic_loss_tangent{anisotropic component1=250.59576 component2=0 component3=0}
  PMLGroup2_XYZ_1: permittivity{anisotropic component1=1.1193654 component2=1.1193654 component3=1.1193654} permeability{anisotropic component1=1.1193654 component2=1.1193654 component3=1.1193654} dielectric_loss_tangent{anisotropic component1=1 component2=1 component3=1} magnetic_loss_tangent{anisotropic component1=1 component2=1 component3=1}
  pec: conductivity=1e+30
  PMLGroup3_Z_1: permittivity{anisotropic component1=1.1193654 component2=1.1193654 component3=0.44668168} permeability{anisotropic component1=1.1193654 component2=1.1193654 component3=0.44668168} dielectric_loss_tangent{anisotropic component1=1 component2=1 component3=-1} magnetic_loss_tangent{anisotropic component1=1 component2=1 component3=-1}
  PMLGroup3_XZ_1: permittivity{anisotropic component1=1 component2=0.01 component3=1} permeability{anisotropic component1=1 component2=0.01 component3=1} dielectric_loss_tangent{anisotropic component1=0 component2=250.59576 component3=0} magnetic_loss_tangent{anisotropic component1=0 component2=250.59576 component3=0}
  PMLGroup3_YZ_1: permittivity{anisotropic component1=0.01 component2=1 component3=1} permeability{anisotropic component1=0.01 component2=1 component3=1} dielectric_loss_tangent{anisotropic component1=250.59576 component2=0 component3=0} magnetic_loss_tangent{anisotropic component1=250.59576 component2=0 component3=0}
  PMLGroup3_XYZ_1: permittivity{anisotropic component1=1.1193654 component2=1.1193654 component3=1.1193654} permeability{anisotropic component1=1.1193654 component2=1.1193654 component3=1.1193654} dielectric_loss_tangent{anisotropic component1=1 component2=1 component3=1} magnetic_loss_tangent{anisotropic component1=1 component2=1 component3=1}
  rhodium: conductivity=22200000
  Rogers RO4003 (tm): permittivity=3.55 dielectric_loss_tangent=0.0027

design HFSSDesign2 (HFSS, HFSS Modal Network, model units mm)
variables:
  cm = 7.5mm
  h = 1.6cm
  l = 7.5cm
  b = 3.8cm
geometry:
  Rectangle1 = rectangle(corner=(0mm, b/2-(1mm), 1.6cm), x_size=10mm, y_size=1.8186533mm)
  Rectangle2 = rectangle(corner=((5 -5) mm, (20-20) mm, 16mm), x_size=0.46mm, y_size=5.49mm)
  Rectangle2.rotate(axis=Z, angle=45deg)
  Rectangle2.move(5.9705041mm, 19.029496mm, 0mm)
  Rectangle2.move(-1.9410081mm, 1.9410081mm, 0mm)
  Rectangle2.move(0.8078695mm, -1.1331386mm, 0mm)
  Rectangle3 = rectangle(corner=(9mm, 22mm, 16cm), x_size=13.3mm, y_size=0.46mm)
  Rectangle3.rotate(axis=Z, angle=45deg)
  Rectangle3.move(10.473006mm, 1.7990715mm, -144mm)
  Rectangle3.move(0.16263456mm, 0.16263456mm, -1.4210855e-14mm)
  Rectangle4 = rectangle(corner=((5 -5) mm, (20-20) mm, 16mm), x_size=0.46mm, y_size=5.49mm)
  Rectangle4.rotate(axis=Z, angle=-45deg)
  Rectangle4.move(5.9705041mm, 19.029496mm, 0mm)
  Rectangle4.move(-1.9410081mm, 1.9410081mm, 0mm)
  Rectangle4.move(0.8078695mm, -1.1331386mm, 0mm)
  Rectangle4.move(3.8373654mm, -6.1626346mm, 0mm)
  Rectangle4.move(0.044650788mm, 0.28061833mm, 0mm)
  Rectangle4.move(-7.7640325mm, 0.32526912mm, 0mm)
  Rectangle5 = rectangle(corner=(9mm, 22mm, 16cm), x_size=13.3mm, y_size=0.46mm)
  Rectangle5.rotate(axis=Z, angle=45deg)
  Rectangle5.move(10.473006mm, 1.7990715mm, -144mm)
  Rectangle5.move(0.16263456mm, 0.16263456mm, -1.4210855e-14mm)
  Rectangle5.move(0.88201623mm, -12.207285mm, 0mm)
  Rectangle5.rotate(axis=Z, angle=(-45-45) deg)
  Rectangle5.move(-10.556747mm, 16.117984mm, 0mm)
  Rectangle6 = rectangle(corner=(7mm, 18mm, 16mm), x_size=1.43mm, y_size=(4.26+0.715) mm)
  Rectangle7 = rectangle(corner=(7mm, 24.26mm, 16mm), x_size=5.14mm, y_size=1.43mm)
  Rectangle2.move(0.65053824mm, -0.32526912mm, 0mm)
  Rectangle2.move(-0.2131728mm, 0.16263456mm, 0mm)
  Rectangle3.move(0.27473088mm, 0mm, 0mm)
  Polyline1 = polyline(z=16mm, xy in mm: (1.3927147, 23.556747) (1.3927147, 24.207285) (1.7179838, 23.882016) (1.3927147, 23.556747), closed, covered)
  Rectangle4.move(0.16263456mm, -0.16263456mm, 0mm)
  Rectangle4.move(0.17473088mm, 0.32526912mm, 0mm)
  Rectangle4.move(0.1mm, 0mm, 0mm)
  Rectangle5.move(0.27473088mm, 0mm, 0mm)
  Polyline2 = polyline(z=16mm, xy in mm: (1.3927147, 13.792715) (1.7179838, 14.117984) (1.3927147, 14.443253) (1.3927147, 13.792715), closed, covered)
  Polyline2.unite(Rectangle4, Rectangle5)
  Rectangle6.move(0mm, 2mm, 0mm)
  Rectangle7.move(1.43mm, 0mm, 0mm)
  Rectangle9 = rectangle(corner=(13.57mm, 24.975mm, 16mm), x_size=1.43mm, y_size=7.88mm)
  [Rectangle9, Rectangle7].move(-0.715mm, 0mm, 0mm)
  Rectangle9.move(2.145mm, 0mm, 0mm)
  Polyline4 = polyline(z=16mm, xy in mm: (7, 24.975) (7.715, 25.69) (7.715, 24.975) (7, 24.975), closed, covered)
  Polyline5 = polyline(z=16mm, xy in mm: (15.715, 25.69) (16.43, 24.975) (15.715, 24.975) (15.715, 25.69), closed, covered)
  [Rectangle9, Polyline5].move(-2.86mm, 0mm, 0mm)
  Rectangle9.move(0mm, -7.88mm, 0mm)
  Rectangle10 = rectangle(corner=(12.855mm, 17.095mm, 16mm), x_size=1.15mm, y_size=5mm)
  Rectangle10.move(-0.575mm, -5mm, 0mm)
  Rectangle11 = rectangle(corner=(12.855mm, 12.095mm, 16mm), x_size=4.92mm, y_size=1.15mm)
  Rectangle11.move(0mm, -0.575mm, 0mm)
  Polyline6 = polyline(z=16mm, xy in mm: (12.855, 11.52) (12.28, 12.095) (12.855, 12.095) (12.855, 11.52), closed, covered)
  Rectangle12 = rectangle(corner=(17.775mm, 12.67mm, 16mm), x_size=1.15mm, y_size=(7.71+1.15/2) mm)
  Rectangle12.move(0mm, -0.575mm, 0mm)
  Rectangle12.move(-0.575mm, 0mm, 0mm)
  Polyline7 = polyline(z=16mm, xy in mm: (17.775, 11.52) (18.35, 12.095) (17.775, 12.095) (17.775, 11.52), closed, covered)
  Rectangle13 = rectangle(corner=(17.775mm, 20.38mm, 16mm), x_size=4.46mm, y_size=1.15mm)
  Rectangle13.move(0mm, -0.575mm, 0mm)
  Polyline8 = polyline(z=16mm, xy in mm: (17.2, 20.38) (17.775, 20.955) (17.775, 20.38) (17.2, 20.38), closed, covered)
  Rectangle6.unite(Rectangle7, Polyline4, Rectangle9, Polyline5, Rectangle10, Polyline6, Polyline7, Rectangle11, Rectangle12, Polyline8, Rectangle13)
  Rectangle6.move(2.285mm, -1mm, 0mm)
  [Rectangle3, Polyline2].move(2.4mm, 0mm, 0mm)
  Rectangle14 = rectangle(corner=(0mm, 0mm, 0mm), x_size=6.05mm, y_size=0.12mm)
  Rectangle14.rotate(axis=Z, angle=90deg)
  Rectangle14.rotate(axis=Z, angle=90deg)
  Rectangle14.rotate(axis=Z, angle=90deg)
  Rectangle15 = rectangle(corner=(-0.12mm, 0.12mm, 0mm), x_size=0.12mm, y_size=8.38mm)
  Rectangle15.rotate(axis=Z, angle=90deg)
  Rectangle15.rotate(axis=Z, angle=90deg)
  Rectangle15.rotate(axis=Z, angle=90deg)
  Rectangle16 = rectangle(corner=(0mm, 8.5mm, 0mm), x_size=4.05mm, y_size=0.12mm)
  Rectangle16.rotate(axis=Z, angle=90deg)
  Rectangle16.rotate(axis=Z, angle=90deg)
  Rectangle16.rotate(axis=Z, angle=90deg)
  Rectangle17 = rectangle(corner=(4.05mm, 8.62mm, 0mm), x_size=0.12mm, y_size=4mm)
  Rectangle17.rotate(axis=Z, angle=90deg)
  Rectangle17.rotate(axis=Z, angle=90deg)
  Rectangle17.rotate(axis=Z, angle=90deg)
  Rectangle18 = rectangle(corner=(4.05mm, 12.62mm, 0mm), x_size=0.7mm, y_size=9mm)
  Rectangle18.rotate(axis=Z, angle=45deg)
  Rectangle18.move(10.109905mm, 0.83252996mm, 0mm)
  Rectangle18.move(-0.24748737mm, -0.24748737mm, 0mm)
  Rectangle18.rotate(axis=Z, angle=90deg)
  Rectangle18.rotate(axis=Z, angle=90deg)
  Rectangle18.rotate(axis=Z, angle=90deg)
  Rectangle19 = rectangle(corner=(-2.5614484mm, 18.736474mm, 0mm), x_size=10.4mm, y_size=0.7mm)
  Rectangle19.move(-10.4mm, 0mm, 0mm)
  Rectangle19.rotate(axis=Z, angle=45deg)
  Rectangle19.move(12.498457mm, 7.2990036mm, 0mm)
  Rectangle19.rotate(axis=Z, angle=90deg)
  Rectangle19.rotate(axis=Z, angle=90deg)
  Rectangle19.rotate(axis=Z, angle=90deg)
  Rectangle20 = rectangle(corner=(4.05mm, 12.62mm, 0mm), x_size=0.35mm, y_size=9.89mm)
  Rectangle20.rotate(axis=Z, angle=90deg)
  Rectangle20.rotate(axis=Z, angle=90deg)
  Rectangle20.rotate(axis=Z, angle=90deg)
  Rectangle21 = rectangle(corner=(4.05mm, 22.51mm, 0mm), x_size=1.5mm, y_size=0.35mm)
  Rectangle21.move(-1.5mm, 0mm, 0mm)
  Rectangle21.rotate(axis=Z, angle=90deg)
  Rectangle21.rotate(axis=Z, angle=90deg)
  Rectangle21.rotate(axis=Z, angle=90deg)
  Rectangle22 = rectangle(corner=(2.55mm, 22.86mm, 0mm), x_size=0.35mm, y_size=7mm)
  Rectangle22.move(-0.35mm, 0mm, 0mm)
  Rectangle22.rotate(axis=Z, angle=90deg)
  Rectangle22.rotate(axis=Z, angle=90deg)
  Rectangle22.rotate(axis=Z, angle=90deg)
  Rectangle23 = rectangle(corner=(2.55mm, 29.86mm, 0mm), x_size=1.57mm, y_size=0.35mm)
  Rectangle23.rotate(axis=Z, angle=90deg)
  Rectangle23.rotate(axis=Z, angle=90deg)
  Rectangle23.rotate(axis=Z, angle=90deg)
  Polyline10 = polyline(z=0mm, xy in mm: (0, 0) (-0.12, 0.12) (0, 0.12) (0, 0), closed, covered)
  Polyline10.move(-0.25mm, -0.17mm, 0mm)
  Polyline10.move(0.25mm, 0.17mm, 0mm)
  Polyline10.rotate(axis=Z, angle=90deg)
  Polyline10.rotate(axis=Z, angle=90deg)
  Polyline10.rotate(axis=Z, angle=90deg)
  Polyline11 = polyline(z=0mm, xy in mm: (-0.12, 8.5) (0, 8.62) (0, 8.5) (-0.12, 8.5), closed, covered)
  Polyline11.rotate(axis=Z, angle=90deg)
  Polyline11.rotate(axis=Z, angle=90deg)
  Polyline11.rotate(axis=Z, angle=90deg)
  Polyline3 = polyline(z=0mm, xy in mm: (4.05, 8.5) (4.17, 8.62) (4.05, 8.62) (4.05, 8.5), closed, covered)
  Polyline3.rotate(axis=Z, angle=90deg)
  Polyline3.rotate(axis=Z, angle=90deg)
  Polyline3.rotate(axis=Z, angle=90deg)
  Polyline12 = polyline(z=0mm, xy in mm: (-2.0664737, 19.231448) (-3.0564232, 19.231448) (-2.5614484, 18.736474) (-2.0664737, 19.231448), closed, covered)
  Polyline12.rotate(axis=Z, angle=90deg)
  Polyline12.rotate(axis=Z, angle=90deg)
  Polyline12.rotate(axis=Z, angle=90deg)
  Polyline13 = polyline(z=0mm, xy in mm: (4.4, 22.51) (4.05, 22.86) (4.05, 22.51) (4.4, 22.51), closed, covered)
  Polyline13.rotate(axis=Z, angle=90deg)
  Polyline13.rotate(axis=Z, angle=90deg)
  Polyline13.rotate(axis=Z, angle=90deg)
  Polyline14 = polyline(z=0mm, xy in mm: (2.55, 22.51) (2.55, 22.86) (2.2, 22.86) (2.55, 22.51), closed, covered)
  Polyline14.rotate(axis=Z, angle=90deg)
  Polyline14.rotate(axis=Z, angle=90deg)
  Polyline14.rotate(axis=Z, angle=90deg)
  Polyline15 = polyline(z=0mm, xy in mm: (2.55, 29.86) (2.55, 30.21) (2.2, 29.86) (2.55, 29.86), closed, covered)
  Polyline15.rotate(axis=Z, angle=90deg)
  Polyline15.rotate(axis=Z, angle=90deg)
  Polyline15.rotate(axis=Z, angle=90deg)
  [Rectangle14..Rectangle23, Polyline10, Polyline11, Polyline3, Polyline12..Polyline15].move(24.4mm, 25.43mm, 16mm)
  [Rectangle14..Rectangle23, Polyline10, Polyline11, Polyline3, Polyline12..Polyline15].move(0.06mm, 0mm, 0mm)
  [Rectangle14..Rectangle23, Polyline10, Polyline11, Polyline3, Polyline12..Polyline15].move(0.06mm, -3.5527137e-15mm, 0mm)
  Rectangle6.move(0.285mm, 0mm, 0mm)
  Rectangle3.move(1.57mm, 0mm, 0mm)
  Rectangle3.move(-1mm, 0mm, 0mm)
  Polyline2.move(0.5mm, 0mm, 0mm)
  Polyline2.move(1.5mm, 0mm, 0mm)
  Polyline2.move(-1.43mm, 0mm, 0mm)
  [Polyline3, Rectangle16, Rectangle17, Rectangle18, Rectangle20, Rectangle14, Rectangle15, Polyline10, Polyline11, Polyline12, Rectangle19, Rectangle21, Polyline13, Polyline14, Rectangle22, Polyline15, Rectangle23].move(0.285mm, 0mm, 0mm)
  Polyline3.unite(Rectangle16, Rectangle17, Rectangle18, Rectangle20, Rectangle14, Rectangle15, Polyline10, Polyline11, Polyline12, Rectangle19, Rectangle21, Polyline13, Polyline14, Rectangle22, Polyline15, Rectangle23)
  Rectangle24 = rectangle(corner=(0mm, 0mm, 0mm), x_size=2.81mm, y_size=5.13mm)
  Rectangle25 = rectangle(corner=(2.81mm, 0mm, 0mm), x_size=3mm, y_size=2.81mm)
  Rectangle25.move(0mm, -2.81mm, 0mm)
  Rectangle26 = rectangle(corner=(5.81mm, 0mm, 0mm), x_size=2.81mm, y_size=2.02mm)
  Rectangle27 = rectangle(corner=(8mm, 4mm, 0mm), x_size=5.12mm, y_size=2.81mm)
  Rectangle27.move(-2mm, 4mm, 0mm)
  Rectangle27.move(1.215mm, -6.99mm, 0mm)
  Rectangle27.move(0.395mm, 4.4408921e-16mm, 0mm)
  Rectangle28 = rectangle(corner=(15mm, 2mm, 0mm), x_size=17.59mm, y_size=4.33mm)
  Rectangle28.move(-2.665mm, -1.75mm, 0mm)
  Rectangle28.move(0.395mm, 8.8817842e-16mm, 0mm)
  Rectangle29 = rectangle(corner=(10mm, -6mm, 0mm), x_size=2.42mm, y_size=9.22mm)
  Rectangle29.move(-1.21mm, -5.22mm, 0mm)
  Rectangle29.rotate(axis=Z, angle=15deg)
  Rectangle29.move(-0.10419544mm, -4.6389632mm, 0mm)
  Rectangle29.move(2.982139mm, 3.196841mm, 0mm)
  Rectangle29.move(-0.20526441mm, 1.6945704mm, 0mm)
  Rectangle29.move(0.44105288mm, -0.76847652mm, 0mm)
  Rectangle29.move(0.26421153mm, -0.92609391mm, 0mm)
  Rectangle29.move(-1.2642115mm, -1.0739061mm, 0mm)
  Rectangle29.move(0.5mm, 0.5mm, 0mm)
  Rectangle29.move(-0.28289423mm, 1.046953mm, 0mm)
  Rectangle29.move(1.3910361mm, 0.8759075mm, 0mm)
  Rectangle29.move(0.0075404996mm, 0.12365791mm, 0mm)
  Rectangle29.move(0.002mm, 0.01mm, 0mm)
  Rectangle29.move(-2.3375405mm, -2.4868996e-14mm, 0mm)
  Rectangle30 = rectangle(corner=(1mm, -12mm, 0mm), x_size=9.14mm, y_size=2.42mm)
  Rectangle30.move(-2.14mm, -1.21mm, 0mm)
  Rectangle30.move(-0.47334125mm, 4.4918307mm, 0mm)
  Rectangle30.rotate(axis=Z, angle=0deg)
  Rectangle30.rotate(axis=Z, angle=-15deg)
  Rectangle30.move(2.3755805mm, 0.13577089mm, 0mm)
  Rectangle31 = rectangle(corner=(1mm, -12mm, 0mm), x_size=9.14mm, y_size=2.42mm)
  Rectangle31.move(13.86mm, -0.21mm, 0mm)
  Rectangle31.move(1.0033412mm, 3.4918307mm, 0mm)
  Rectangle31.move(-0.73748915mm, -1.5976668mm, 0mm)
  Rectangle31.rotate(axis=Z, angle=15deg)
  Rectangle31.move(-1.5281919mm, -4.1839027mm, 0mm)
  Polyline17 = polyline(z=0mm, xy in mm: (0, 0) (2.81, -2.81) (2.81, 0) (0, 0), closed, covered)
  Polyline18 = polyline(z=0mm, xy in mm: (5.81, -2.81) (8.62, 0) (5.81, 0) (5.81, -2.81), closed, covered)
  Rectangle32 = rectangle(corner=(10mm, -6mm, 0mm), x_size=2.42mm, y_size=9.22mm)
  Rectangle32.move(-1.21mm, -5.22mm, 0mm)
  Rectangle32.rotate(axis=Z, angle=-15deg)
  Rectangle32.move(-0.10419544mm, -4.6389632mm, 0mm)
  Rectangle32.move(2.982139mm, 3.196841mm, 0mm)
  Rectangle32.move(-0.20526441mm, 1.6945704mm, 0mm)
  Rectangle32.move(0.44105288mm, -0.76847652mm, 0mm)
  Rectangle32.move(0.26421153mm, -0.92609391mm, 0mm)
  Rectangle32.move(-1.2642115mm, -1.0739061mm, 0mm)
  Rectangle32.move(0.5mm, 0.5mm, 0mm)
  Rectangle32.move(-0.28289423mm, 1.046953mm, 0mm)
  Rectangle32.move(14.594664mm, -12.769539mm, 0mm)
  Rectangle32.move(8.1260766mm, 0.24956542mm, 0mm)
  Rectangle32.move(-24.023005mm, 17.696355mm, 0mm)
  Rectangle32.move(1.3910361mm, 0.8759075mm, 0mm)
  Rectangle32.move(0.0075404996mm, 0.12365791mm, 0mm)
  Rectangle32.move(0.002mm, 0.01mm, 0mm)
  Polyline20 = polyline(z=0mm, xy in mm: (7.3893463, -10.233377) (10.353229, -8.5221782) (8.0156884, -7.8958361) (7.3893463, -10.233377), closed, covered)
  Polyline21 = polyline(z=0mm, xy in mm: (12.788312, -8.5221782) (15.752194, -10.233377) (15.125852, -7.8958361) (12.788312, -8.5221782), closed, covered)
  [Rectangle24..Rectangle31, Polyline17, Polyline18, Rectangle32, Polyline20, Polyline21].move(24.805mm, 14.25mm, 16mm)
  [Rectangle24..Rectangle31, Polyline17, Polyline18, Rectangle32, Polyline20, Polyline21].move(0mm, -0.575mm, 0mm)
  Rectangle6.unite(Polyline3)
  Polyline23 = polyline(z=16mm, xy in mm: (27.615, 17.495) (25.73, 19.38) (25.73, 17.495) (27.615, 17.495), closed, covered)
  Polyline24 = polyline(z=16mm, xy in mm: (27.615, 17.495) (27.615, 18.805) (26.305, 18.805) (27.615, 17.495), closed, covered)
  Rectangle24.subtract(Polyline24)
  Rectangle33 = rectangle(corner=(25.4mm, 20.6mm, 0mm), x_size=0.925mm, y_size=0.575mm)
  Rectangle33.move(-0.595mm, -1.795mm, 16mm)
  Rectangle34 = rectangle(corner=(0mm, (-5-2) mm, 0mm), x_size=(8+3.04) mm, y_size=3.04mm)
  Polyline26 = polyline(z=0mm, xy in mm: (11.04, -7) (8, -3.96) (11.04, -3.96) (11.04, -7), closed, covered)
  Rectangle34.subtract(Polyline26)
  Rectangle35 = rectangle(corner=(11.04mm, -7mm, 0mm), x_size=-3.04mm, y_size=-8.56mm)
  Rectangle36 = rectangle(corner=((9.52-0.52) mm, -15.56mm, 0mm), x_size=1.8186533mm, y_size=8mm)
  Rectangle36.move(-1mm, -8mm, 0mm)
  Rectangle36.move(0.52mm, 0mm, 0mm)
  Rectangle37 = rectangle(corner=((9.08-0.4) mm, 5.39mm, 0mm), x_size=1.8186533mm, y_size=8mm)
  Rectangle37.move(0.91mm, 1mm, 0mm)
  Rectangle38 = rectangle(corner=((10.06-0.98) mm, -3mm, 0mm), x_size=0.98mm, y_size=8.39mm)
  Rectangle38.move(0.49mm, 1mm, 0mm)
  Rectangle38.move(0.49mm, 0mm, 0mm)
  Rectangle39 = rectangle(corner=(1.5mm, -1mm, 0mm), x_size=(10.06+0.98/2) mm, y_size=0.98mm)
  Rectangle39.move(-1.5mm, -1.49mm, 0mm)
  Polyline25 = polyline(z=0mm, xy in mm: (10.55, -2.49) (11.04, -2) (10.55, -2) (10.55, -2.49), closed, covered)
  [Rectangle34..Rectangle39, Polyline25].move(55.015mm, 22.82mm, 16mm)
  Rectangle39.move(0mm, 0.98mm, 0mm)
  Rectangle39.move(0mm, -0.35mm, 0mm)
  Polyline27 = polyline(z=16mm, xy in mm: (55.015, 20.96) (54.665, 21.31) (55.015, 21.31) (55.015, 20.96), closed, covered)
  Rectangle34.move(0.11mm, -1.25mm, 0mm)
  Rectangle28.move(-0.135mm, -0.005mm, 0mm)
  Rectangle28.move(0.025mm, 0mm, 0mm)
  Rectangle28.move(-2.1316282e-14mm, -0.105mm, 0mm)
  Polyline28 = polyline(z=16mm, xy in mm: (30.615, 15.695) (32.305, 15.695) (32.305, 17.385) (30.615, 15.695), closed, covered)
  [Rectangle29, Rectangle31, Polyline21].move(13.45546mm, -2.685mm, 0mm)
  [Rectangle29, Rectangle31, Polyline21, Rectangle32, Rectangle30, Polyline20].move(0.293mm, -0.185mm, 0mm)
  Rectangle32.move(-0.4125405mm, -0.058657911mm, 0mm)
  Rectangle32.move(7.1054274e-15mm, 0.13365791mm, 0mm)
  [Polyline20, Rectangle30].move(-0.4125405mm, 0.075mm, 0mm)
  [Rectangle31, Rectangle29, Polyline21].move(-11.53046mm, 2.76mm, 0mm)
  Rectangle40 = rectangle(corner=(37.425mm, 13.815mm, 16mm), x_size=-2.3375405mm, y_size=0.76mm)
  [Rectangle29, Rectangle31, Polyline21].move(-1.1687702mm, 0mm, 0mm)
  Rectangle3.move(0mm, 1.8mm, 0mm)
  Rectangle3.move(-0.095116484mm, 0.28447837mm, 0mm)
  Rectangle3.move(-0.080451402mm, 0.017278769mm, 0mm)
  Rectangle3.move(0.27814404mm, -0.0078222875mm, 0mm)
  Rectangle3.move(-0.10215271mm, 0.0034751892mm, 0mm)
  Rectangle45 = rectangle(corner=(37.425423mm, 23.12741mm, 16mm), x_size=1.3724116mm, y_size=-2.885mm)
  Rectangle47 = rectangle(corner=(55.015423mm, 23.05741mm, 16mm), x_size=1.5563824mm, y_size=-3.46mm)
  Box2 [Rogers RO4003 (tm)] = box(corner=(0.00042344472mm, 39.93741mm, 16mm), size=(75mm, -39.94mm, -0.813mm))
  Rectangle50 = rectangle(corner=(0.00042344472mm, 22.09741mm, 16mm), y_size=-1.8186533mm, z_size=-0.813mm)
  Rectangle53 = rectangle(corner=(66.605423mm, 39.93741mm, 16mm), z_size=-0.813mm, x_size=-1.8186533mm)
  Rectangle56 = rectangle(corner=(63.535423mm, -0.0025899568mm, 16mm), z_size=-0.813mm, x_size=1.8186533mm)
  RadiatingSurface [vacuum] = region(absolute_offset=31.25mm on all sides)
  coordinate_system FaceCS1 = face of RadiatingSurface: Origin=(106.25042, -31.25259, 47.25) FaceID=RadiatingSurface.face(+z) AxisPosn=(106.25042, 71.18741, 47.25) WhichAxis=X ZRotationAngle=0deg XOffset=0mm YOffset=0mm FaceNormal(0, 0, 1)
  PML_RadiatingSurface_1 [PMLGroup2_Z_1, oriented by FaceCS1] = sweep_along_normal(RadiatingSurface.face(+z), length=49.932655mm)
  coordinate_system FaceCS2 = face of RadiatingSurface: Origin=(106.25042, -31.25259, -16.063) FaceID=RadiatingSurface.face(-z) AxisPosn=(-31.249577, -31.25259, -16.063) WhichAxis=X ZRotationAngle=0deg XOffset=0mm YOffset=0mm FaceNormal(0, 0, -1)
  PML_RadiatingSurface_2 [PMLGroup2_Z_1, oriented by FaceCS2] = sweep_along_normal(RadiatingSurface.face(-z), length=49.932655mm)
  coordinate_system FaceCS3 = face of RadiatingSurface: Origin=(106.25042, -31.25259, 47.25) FaceID=RadiatingSurface.face(-y) AxisPosn=(-31.249577, -31.25259, 47.25) WhichAxis=X ZRotationAngle=0deg XOffset=0mm YOffset=0mm FaceNormal(0, -1, 0)
  PML_RadiatingSurface_3 [PMLGroup2_Z_1, oriented by FaceCS3] = sweep_along_normal(RadiatingSurface.face(-y), length=49.932655mm)
  coordinate_system FaceCS4 = face of RadiatingSurface: Origin=(-31.249577, -31.25259, 47.25) FaceID=RadiatingSurface.face(-x) AxisPosn=(-31.249577, 71.18741, 47.25) WhichAxis=X ZRotationAngle=0deg XOffset=0mm YOffset=0mm FaceNormal(-1, 0, 0)
  PML_RadiatingSurface_4 [PMLGroup2_Z_1, oriented by FaceCS4] = sweep_along_normal(RadiatingSurface.face(-x), length=49.932655mm)
  coordinate_system FaceCS5 = face of RadiatingSurface: Origin=(-31.249577, 71.18741, 47.25) FaceID=RadiatingSurface.face(+y) AxisPosn=(106.25042, 71.18741, 47.25) WhichAxis=X ZRotationAngle=0deg XOffset=0mm YOffset=0mm FaceNormal(0, 1, 0)
  PML_RadiatingSurface_5 [PMLGroup2_Z_1, oriented by FaceCS5] = sweep_along_normal(RadiatingSurface.face(+y), length=49.932655mm)
  coordinate_system FaceCS6 = face of RadiatingSurface: Origin=(106.25042, 71.18741, -16.063) FaceID=RadiatingSurface.face(+x) AxisPosn=(106.25042, 71.18741, 47.25) WhichAxis=X ZRotationAngle=0deg XOffset=0mm YOffset=0mm FaceNormal(1, 0, 0)
  PML_RadiatingSurface_6 [PMLGroup2_Z_1, oriented by FaceCS6] = sweep_along_normal(RadiatingSurface.face(+x), length=49.932655mm)
  PML_RadiatingSurface_7 [PMLGroup2_XZ_1, oriented by FaceCS1] = sweep_along_normal(PML_RadiatingSurface_1.face(at (37.5004, -31.2526, 72.2163)), length=49.932655mm)
  PML_RadiatingSurface_8 [PMLGroup2_YZ_1, oriented by FaceCS4] = sweep_along_normal(PML_RadiatingSurface_1.face(at (-31.2496, 19.9674, 72.2163)), length=49.932655mm)
  PML_RadiatingSurface_9 [PMLGroup2_YZ_1, oriented by FaceCS5] = sweep_along_normal(PML_RadiatingSurface_1.face(at (37.5004, 71.1874, 72.2163)), length=49.932655mm)
  PML_RadiatingSurface_10 [PMLGroup2_YZ_1, oriented by FaceCS1] = sweep_along_normal(PML_RadiatingSurface_1.face(at (106.25, 19.9674, 72.2163)), length=49.932655mm)
  PML_RadiatingSurface_11 [PMLGroup2_YZ_1, oriented by FaceCS2] = sweep_along_normal(PML_RadiatingSurface_2.face(at (37.5004, -31.2526, -41.0293)), length=49.932655mm)
  coordinate_system FaceCS7 = face of RadiatingSurface: Origin=(-31.249577, -31.25259, -16.063) FaceID=RadiatingSurface.face(-z) AxisPosn=(-31.249577, 71.18741, -16.063) WhichAxis=X ZRotationAngle=0deg XOffset=0mm YOffset=0mm FaceNormal(0, 0, -1)
  PML_RadiatingSurface_12 [PMLGroup2_YZ_1, oriented by FaceCS7] = sweep_along_normal(PML_RadiatingSurface_2.face(at (-31.2496, 19.9674, -41.0293)), length=49.932655mm)
  coordinate_system FaceCS8 = face of RadiatingSurface: Origin=(-31.249577, 71.18741, -16.063) FaceID=RadiatingSurface.face(-z) AxisPosn=(106.25042, 71.18741, -16.063) WhichAxis=X ZRotationAngle=0deg XOffset=0mm YOffset=0mm FaceNormal(0, 0, -1)
  PML_RadiatingSurface_13 [PMLGroup2_YZ_1, oriented by FaceCS8] = sweep_along_normal(PML_RadiatingSurface_2.face(at (37.5004, 71.1874, -41.0293)), length=49.932655mm)
  PML_RadiatingSurface_14 [PMLGroup2_XZ_1, oriented by FaceCS2] = sweep_along_normal(PML_RadiatingSurface_2.face(at (106.25, 19.9674, -41.0293)), length=49.932655mm)
  PML_RadiatingSurface_15 [PMLGroup2_XZ_1, oriented by FaceCS4] = sweep_along_normal(PML_RadiatingSurface_3.face(at (-31.2496, -56.2189, 15.5935)), length=49.932655mm)
  PML_RadiatingSurface_16 [PMLGroup2_XZ_1, oriented by FaceCS3] = sweep_along_normal(PML_RadiatingSurface_3.face(at (106.25, -56.2189, 15.5935)), length=49.932655mm)
  PML_RadiatingSurface_17 [PMLGroup2_XZ_1, oriented by FaceCS5] = sweep_along_normal(PML_RadiatingSurface_4.face(at (-56.2159, 71.1874, 15.5935)), length=49.932655mm)
  PML_RadiatingSurface_18 [PMLGroup2_YZ_1, oriented by FaceCS6] = sweep_along_normal(PML_RadiatingSurface_5.face(at (106.25, 96.1537, 15.5935)), length=49.932655mm)
  PML_RadiatingSurface_19 [PMLGroup2_XYZ_1, oriented by FaceCS4] = sweep_along_normal(PML_RadiatingSurface_7.face(at (-31.2496, -56.2189, 72.2163)), length=49.932655mm)
  PML_RadiatingSurface_20 [PMLGroup2_XYZ_1, oriented by FaceCS1] = sweep_along_normal(PML_RadiatingSurface_7.face(at (106.25, -56.2189, 72.2163)), length=49.932655mm)
  PML_RadiatingSurface_21 [PMLGroup2_XYZ_1, oriented by FaceCS5] = sweep_along_normal(PML_RadiatingSurface_8.face(at (-56.2159, 71.1874, 72.2163)), length=49.932655mm)
  coordinate_system FaceCS9 = face of RadiatingSurface: Origin=(106.25042, 71.18741, 47.25) FaceID=RadiatingSurface.face(+z) AxisPosn=(-31.249577, 71.18741, 47.25) WhichAxis=X ZRotationAngle=0deg XOffset=0mm YOffset=0mm FaceNormal(0, 0, 1)
  PML_RadiatingSurface_22 [PMLGroup2_XYZ_1, oriented by FaceCS9] = sweep_along_normal(PML_RadiatingSurface_9.face(at (106.25, 96.1537, 72.2163)), length=49.932655mm)
  PML_RadiatingSurface_23 [PMLGroup2_XYZ_1, oriented by FaceCS7] = sweep_along_normal(PML_RadiatingSurface_11.face(at (-31.2496, -56.2189, -41.0293)), length=49.932655mm)
  PML_RadiatingSurface_24 [PMLGroup2_XYZ_1, oriented by FaceCS2] = sweep_along_normal(PML_RadiatingSurface_11.face(at (106.25, -56.2189, -41.0293)), length=49.932655mm)
  PML_RadiatingSurface_25 [PMLGroup2_XYZ_1, oriented by FaceCS8] = sweep_along_normal(PML_RadiatingSurface_12.face(at (-56.2159, 71.1874, -41.0293)), length=49.932655mm)
  PML_RadiatingSurface_26 [PMLGroup2_XYZ_1, oriented by FaceCS6] = sweep_along_normal(PML_RadiatingSurface_13.face(at (106.25, 96.1537, -41.0293)), length=49.932655mm)
  Cylinder1 [pec] = cylinder(axis=Z, base_centre=(50.435409mm, 7.7946395mm, 16mm), radius=0.2mm, height=-0.813mm)
  Cylinder1.move(3.8731809mm, -7.0069704mm, 0mm)
  Cylinder1.move(1.7340045mm, 0.25364875mm, 0mm)
  Cylinder1.move(-5.9203564mm, 7.9220919mm, -8.132927432mm)
  Cylinder2 [pec] = cylinder(axis=Z, base_centre=(50.435409mm, 7.7946395mm, 16mm), radius=0.3mm, height=-0.813mm)
  Cylinder2.move(3.8731809mm, -7.0069704mm, 0mm)
  Cylinder2.move(1.7340045mm, 0.25364875mm, 0mm)
  Cylinder2.move(-5.9203564mm, 7.9220919mm, -8.132927432mm)
  Cylinder2.move(-26.5624mm, 1.2434498e-14mm, 0mm)
  Cylinder3 [pec] = cylinder(axis=Z, base_centre=(50.435409mm, 7.7946395mm, 16mm), radius=0.3mm, height=-0.813mm)
  Cylinder3.move(3.8731809mm, -7.0069704mm, 0mm)
  Cylinder3.move(1.7340045mm, 0.25364875mm, 0mm)
  Cylinder3.move(-5.9203564mm, 7.9220919mm, -8.132927432mm)
  Cylinder1.move(-36.782067mm, -2.2002864mm, 0mm)
  Cylinder1.move(0.59012104mm, -0.11488432mm, 0mm)
  Cylinder4 [pec] = cylinder(axis=Z, base_centre=(50.435409mm, 7.7946395mm, 16mm), radius=0.2mm, height=0.813mm)
  Cylinder4.move(3.8731809mm, -7.0069704mm, 0mm)
  Cylinder4.move(1.7340045mm, 0.25364875mm, 0mm)
  Cylinder4.move(-5.9203564mm, 7.9220919mm, -8.132927432mm)
  Cylinder4.move(-36.782067mm, -2.2002864mm, 0mm)
  Cylinder4.move(0.59012104mm, -0.11488432mm, 0mm)
  Cylinder4.move(0mm, 28.898342mm, 0mm)
  Cylinder5 [pec] = cylinder(axis=Z, base_centre=(50.435409mm, 7.7946395mm, 16mm), radius=0.2mm, height=-0.813mm)
  Cylinder5.move(3.8731809mm, -7.0069704mm, 0mm)
  Cylinder5.move(1.7340045mm, 0.25364875mm, 0mm)
  Cylinder5.move(-5.9203564mm, 7.9220919mm, -8.132927432mm)
  Cylinder5.move(-36.782067mm, -2.2002864mm, 0mm)
  Cylinder5.move(0.59012104mm, -0.11488432mm, 0mm)
  Cylinder5.move(0mm, 28.898342mm, 0mm)
  Cylinder5.move(22.505181mm, 2.1436753mm, 0mm)
  Cylinder4.move(0mm, 4.9737992e-14mm, 7.319927432mm)
  Cylinder1.move(0mm, 1.7763568e-15mm, 8.132927432mm)
  Cylinder2.move(-3.1974423e-14mm, 0mm, 8.132927432mm)
  Cylinder3.move(0mm, -1.7763568e-15mm, 8.132927432mm)
  Cylinder5.move(0mm, 0mm, 8.132927432mm)
  Rectangle1.move(0.00042344472mm, 2.1880834mm, 0mm)
  Rectangle50.move(-5.5836412e-18mm, -0.090673357mm, 0mm)
  [Rectangle2, Polyline1].move(2.9704234mm, 2.09741mm, 0mm)
  Rectangle37.move(-0.39783169mm, 0.095604675mm, 0mm)
  Rectangle37.move(0.44850505mm, -0.095604675mm, 0mm)
  Rectangle36.move(-0.46771855mm, -0.63167222mm, 0mm)
  Rectangle36.move(0.55839191mm, 0.63167222mm, 0mm)
  Polyline25.move(-0.49mm, 0mm, 0mm)
  Rectangle6.move(0.43042344mm, 2.6180834mm, 0mm)
  Rectangle6.move(0mm, -0.715mm, 0mm)
  Rectangle6.move(-2.6645353e-14mm, 0.19432664mm, 0mm)
  Rectangle6.move(-0.52067336mm, 0mm, 0mm)
  Polyline29 = polyline(z=16mm, xy in mm: (10.000423, 20.188083) (10.90975, 21.09741) (10.000423, 21.09741) (10.000423, 20.188083), closed, covered)
  Rectangle33.unite(Polyline23, Rectangle24, Polyline17, Polyline18, Rectangle25, Rectangle26, Polyline28)
  Rectangle33.move(-0.090249912mm, 2.09741mm, 0mm)
  Rectangle27.move(-0.20024991mm, 1.98741mm, 0mm)
  [Rectangle28, Rectangle40, Rectangle32, Rectangle29, Polyline20, Rectangle30, Rectangle31, Polyline21].move(-0.090249912mm, 2.09741mm, 0mm)
  Rectangle34.move(-0.20024991mm, 1.98741mm, 0mm)
  [Rectangle36, Rectangle35].move(-0.090249912mm, 0.73741004mm, 0mm)
  [Polyline27, Rectangle39].move(-0.090249912mm, 2.09741mm, 0mm)
  [Rectangle38, Rectangle37].move(0.39975009mm, 3.21741mm, 0mm)
  [Rectangle37, Rectangle38].move(-0.49mm, -0.49mm, 0mm)
  Polyline25.move(0.39975009mm, 2.72741mm, 0mm)
  Polyline2.move(0.00042344472mm, 2.09741mm, 0mm)
  [Cylinder4, Rectangle2, Polyline1, Rectangle3].move(0mm, -0.090673357mm, 0mm)
  [Cylinder1, Polyline2].move(0mm, 0.090673357mm, 0mm)
  Rectangle45.move(-0.090673357mm, 3.5527137e-15mm, 0mm)
  Rectangle47.move(-0.090673357mm, 0mm, 0mm)
  Rectangle53.move(-0.22134671mm, 0mm, 0mm)
  Rectangle1.unite(Rectangle2, Rectangle3, Polyline1, Rectangle6, Polyline2, Polyline29, Rectangle33, Rectangle28, Rectangle27, Rectangle29, Rectangle40, Rectangle32, Rectangle30, Polyline20, Rectangle31, Polyline21, Rectangle37, Rectangle38, Polyline25, Rectangle39, Polyline27, Rectangle34, Rectangle35, Rectangle36)
  Cylinder6 [pec] = cylinder(axis=Z, base_centre=(50.435409mm, 7.7946395mm, 16mm), radius=0.3mm, height=-0.813mm)
  Cylinder6.move(3.8731809mm, -7.0069704mm, 0mm)
  Cylinder6.move(1.7340045mm, 0.25364875mm, 0mm)
  Cylinder6.move(-5.9203564mm, 7.9220919mm, -8.132927432mm)
  Cylinder6.move(-26.5624mm, 1.2434498e-14mm, 0mm)
  Cylinder6.move(-3.1974423e-14mm, 0mm, 8.132927432mm)
  Cylinder6.move(0.52200802mm, 0.47786819mm, 0mm)
  Cylinder2.move(0.21569928mm, -0.67529667mm, 0mm)
  Cylinder3.move(-0.85805912mm, 0.42531788mm, 0mm)
  Cylinder7 [pec] = cylinder(axis=Z, base_centre=(50.435409mm, 7.7946395mm, 16mm), radius=0.3mm, height=-0.813mm)
  Cylinder7.move(3.8731809mm, -7.0069704mm, 0mm)
  Cylinder7.move(1.7340045mm, 0.25364875mm, 0mm)
  Cylinder7.move(-5.9203564mm, 7.9220919mm, -8.132927432mm)
  Cylinder7.move(0mm, -1.7763568e-15mm, 8.132927432mm)
  Cylinder7.move(-0.85805912mm, 0.42531788mm, 0mm)
  Cylinder7.move(0.34268761mm, -1.170846mm, 0mm)
  group PMLGroup2 = PML_RadiatingSurface_1..PML_RadiatingSurface_26
boundaries and excitations:
  LumpRLC1: Lumped RLC Objects=Rectangle45 CurrentLine{(38.020956, 20.24241, 16) -> (38.020956, 23.12741, 16)} RLC_Type=Parallel Resistance=91ohm
  LumpRLC2: Lumped RLC Objects=Rectangle47 CurrentLine{(55.702941, 19.59741, 16) -> (55.702941, 23.05741, 16)} RLC_Type=Parallel Resistance=120ohm
  PerfE2: Perfect E Faces=Box2.face(-z)
  PML_radiation1: Radiation Faces=RadiatingSurface.face(+z) IsForPML
  PML_radiation2: Radiation Faces=RadiatingSurface.face(-z) IsForPML
  PML_radiation3: Radiation Faces=RadiatingSurface.face(-y) IsForPML
  PML_radiation4: Radiation Faces=RadiatingSurface.face(-x) IsForPML
  PML_radiation5: Radiation Faces=RadiatingSurface.face(+y) IsForPML
  PML_radiation6: Radiation Faces=RadiatingSurface.face(+x) IsForPML
  PerfE3: Perfect E Objects=Rectangle1
  1: Lumped Port Objects=Rectangle50 LumpedPortType=Modal Modes{Mode1{IntLine{(0.00042344472, 21.09741, 15.187) -> (0.00042344472, 21.09741, 16)} CharImp=Zpi}} Impedance=50ohm
  2: Lumped Port Objects=Rectangle56 LumpedPortType=Modal Modes{Mode1{IntLine{(64.44475, -0.0025899568, 15.187) -> (64.44475, -0.0025899568, 16)} CharImp=Zpi}} Impedance=50ohm
  3: Lumped Port Objects=Rectangle53 LumpedPortType=Modal Modes{Mode1{IntLine{(65.47475, 39.93741, 15.187) -> (65.47475, 39.93741, 16)} CharImp=Zpi}} Impedance=50ohm
setups:
  Setup1: HfssDriven Frequency=2.4GHz MaxDeltaS=0.02 MaximumPasses=6 MinimumPasses=1 MinimumConvergedPasses=1 PercentRefinement=30 BasisOrder=1 PortAccuracy=2 DrivenSolverType="Direct Solver"
    sweep Sweep: 1GHz to 4.8GHz, 401 points; Type=Interpolating InterpTolerance=0.5 InterpMaxSolns=250 InterpUsePortImped=false PassivityErrorTolerance=0.0001
source amplitudes:
  1:1: 1W 0deg
  2:1, 3:1: 0W 0deg
radiation setups:
  3D: Infinite Sphere Theta=0deg..180deg step 2deg Phi=-180deg..180deg step 2deg
  Elevation: Infinite Sphere Theta=-180deg..180deg step 1deg Phi=0deg..90deg step 90deg
  Azimuth: Infinite Sphere Theta=90deg..90deg step 0deg Phi=-180deg..180deg step 1deg
field plots:
  Mag_E1: E Field over Rectangle1.face(at (33.1923, 19.9674, 16)) on Setup1 : LastAdaptive at Freq=2.4GHz Phase=0deg
reports:
  S Parameter Plot 1: dB(S(1,1)), dB(S(2,1)), dB(S(3,1)) vs Freq on Setup1 : Sweep; markers m1 at 1.3895GHz, m2 at 1.9405GHz, m3 at 2.748GHz, m4 at 3.451GHz, m5 at 1.9975GHz, m6 at 1.9975GHz
  S Parameter Plot 2: dB(S(2,2)), dB(S(3,2)), dB(S(3,3)) vs Freq on Setup1 : Sweep
